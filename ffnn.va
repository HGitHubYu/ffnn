`include "disciplines.vams"

module osc(inp_0, inp_1, inp_2, inp_3, outp_1, outp_2);
inout inp_0, inp_1, inp_2, inp_3, outp_1, outp_2;
electrical inp_0, inp_1, inp_2, inp_3, outp_1, outp_2;

real ACT[0:17];
real weights_value[0:79] = {-0.788, -0.166, -0.776, 0.194, -0.796, 0.144, 0.794, -0.532, -0.344, -0.794, -0.536, -0.612, 0.214, 0.258, 0.6, -0.888, 0.122, 0.448, -0.038, -0.838, -0.128, -0.636, 0.98, 0.916, -0.95, 0.692, 0.39, 0.894, 0.302, -0.134, 0.61, -0.782, 0.702, -0.462, 0.412, -0.39, -0.612, 0.912, 0.078, 0.044, -0.882, -0.754, -0.862, -0.964, 0.504, 0.738, -0.85, -0.374, 0.188, 0.112, 0.492, -0.94, -0.82, -0.824, -0.32, -0.064, 0.87, -0.224, -0.17, 0.876, 0.642, 0.144, -0.906, -0.952, 0.684, -0.788, 0.362, -0.928, -0.876, 0.144, 0.116, -0.054, 0.392, 0.254, -0.016, -0.104, 0.698, 0.134, -0.772, -0.114};
real unit_input_sum;

integer weights_source[0:79] = {0, 1, 2, 3, 0, 1, 2, 3, 0, 1, 2, 3, 0, 1, 2, 3, 0, 1, 2, 3, 0, 1, 2, 3, 0, 1, 2, 3, 0, 4, 5, 6, 7, 8, 9, 10, 0, 4, 5, 6, 7, 8, 9, 10, 0, 4, 5, 6, 7, 8, 9, 10, 0, 4, 5, 6, 7, 8, 9, 10, 0, 4, 5, 6, 7, 8, 9, 10, 0, 11, 12, 13, 14, 15, 0, 11, 12, 13, 14, 15};
integer weights_dest[0:80] = {4, 4, 4, 4, 5, 5, 5, 5, 6, 6, 6, 6, 7, 7, 7, 7, 8, 8, 8, 8, 9, 9, 9, 9, 10, 10, 10, 10, 11, 11, 11, 11, 11, 11, 11, 11, 12, 12, 12, 12, 12, 12, 12, 12, 13, 13, 13, 13, 13, 13, 13, 13, 14, 14, 14, 14, 14, 14, 14, 14, 15, 15, 15, 15, 15, 15, 15, 15, 16, 16, 16, 16, 16, 16, 17, 17, 17, 17, 17, 17, -1};
integer Weight_Index, dest, nextDest;

	analog begin
		ACT[0] = V(inp_0);
		ACT[1] = V(inp_1);
		ACT[2] = V(inp_2);
		ACT[3] = V(inp_3);
		Weight_Index=0;
		nextDest=4;
		while (Weight_Index<80) begin
			unit_input_sum=0;
			dest=nextDest;
			while(dest==nextDest) begin
				unit_input_sum=unit_input_sum+weights_value[Weight_Index]*ACT[weights_source[Weight_Index]];
				Weight_Index=Weight_Index+1;
				nextDest=weights_dest[Weight_Index];
			end
			if(dest> 15) begin
				ACT[dest]=unit_input_sum;
			end else begin
				ACT[dest]= (exp(unit_input_sum)-exp(-unit_input_sum)) / (exp(unit_input_sum)+exp(-unit_input_sum));
			end
		end
		V(outp_1) <+ ACT[16];
		V(outp_2) <+ ACT[17];
	end

endmodule
